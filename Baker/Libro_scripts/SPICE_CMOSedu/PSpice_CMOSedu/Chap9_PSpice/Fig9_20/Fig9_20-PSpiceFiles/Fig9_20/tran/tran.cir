** Profile: "Fig9_20-tran"  [ C:\Users\jbaker\Desktop\Chap9_PSpice\Fig9_20\Fig9_20-pspicefiles\Fig9_20\tran.sim ]

** Creating circuit file "tran.cir"
** WARNING: THIS AUTOMATICALLY GENERATED FILE MAY BE OVERWRITTEN BY SUBSEQUENT SIMULATIONS

*Libraries:
* Profile Libraries :
* Local Libraries :
.LIB "../../../Fig9_20-pspicefiles/Fig9_20.lib"
* From [PSPICE NETLIST] section of C:\SPB_Data\cdssetup\OrCAD_PSpice/16.6.0/PSpice.ini file:
.lib "nom.lib"

*Analysis directives:
.TRAN  0 300u 0 0.1u
.OPTIONS ADVCONV
.PROBE64 V(alias(*)) I(alias(*)) W(alias(*)) D(alias(*)) NOISE(alias(*))
.INC "..\Fig9_20.net"

.END
