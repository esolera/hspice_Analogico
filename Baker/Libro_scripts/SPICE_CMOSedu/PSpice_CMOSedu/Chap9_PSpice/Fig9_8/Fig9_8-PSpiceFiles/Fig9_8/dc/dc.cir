** Profile: "Fig9_8-dc"  [ C:\Users\jbaker\Desktop\Chap9_PSpice\Fig9_8\fig9_8-pspicefiles\fig9_8\dc.sim ]

** Creating circuit file "dc.cir"
** WARNING: THIS AUTOMATICALLY GENERATED FILE MAY BE OVERWRITTEN BY SUBSEQUENT SIMULATIONS

*Libraries:
* Profile Libraries :
* Local Libraries :
.LIB "../../../Fig9_8-pspicefiles/Fig9_8.lib"
* From [PSPICE NETLIST] section of C:\SPB_Data\cdssetup\OrCAD_PSpice/16.6.0/PSpice.ini file:
.lib "nom.lib"

*Analysis directives:
.DC LIN I_Injected -1u 1u 10n
.OPTIONS ADVCONV
.PROBE64 V(alias(*)) I(alias(*)) W(alias(*)) D(alias(*)) NOISE(alias(*))
.INC "..\Fig9_8.net"

.END
