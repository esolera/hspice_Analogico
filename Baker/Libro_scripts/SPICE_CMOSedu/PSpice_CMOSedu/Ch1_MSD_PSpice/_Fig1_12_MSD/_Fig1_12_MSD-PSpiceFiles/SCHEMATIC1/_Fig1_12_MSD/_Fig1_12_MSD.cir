** Profile: "SCHEMATIC1-_Fig1_12_MSD"  [ C:\Users\HomePC\Documents\Spring 2013\PSpice_CMOSedu\MSD\Ch1_MSD_Pspice\_Fig1_12_MSD\_fig1_12_msd-pspicefiles\schematic1\_fig1_12_msd.sim ]

** Creating circuit file "_Fig1_12_MSD.cir"
** WARNING: THIS AUTOMATICALLY GENERATED FILE MAY BE OVERWRITTEN BY SUBSEQUENT SIMULATIONS

*Libraries:
* Profile Libraries :
* Local Libraries :
* From [PSPICE NETLIST] section of C:\Cadence\SPB_16.3\tools\PSpice\PSpice.ini file:
.lib "nom.lib"

*Analysis directives:
.AC LIN 1000 10k 500Meg
.PROBE V(alias(*)) I(alias(*)) W(alias(*)) D(alias(*)) NOISE(alias(*))
.INC "..\SCHEMATIC1.net"

.END
